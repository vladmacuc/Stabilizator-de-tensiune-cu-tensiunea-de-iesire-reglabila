** Profile: "SCHEMATIC1-STB"  [ C:\Users\user\Desktop\Tehnici CAD\MacucVlad_FINAL\Proiect CAD final\stabilizatordetensiune_2-pspicefiles\schematic1\stb.sim ]

** Creating circuit file "STB.cir"
** WARNING: THIS AUTOMATICALLY GENERATED FILE MAY BE OVERWRITTEN BY SUBSEQUENT SIMULATIONS

*Libraries:
* Profile Libraries :
* Local Libraries :
* From [PSPICE NETLIST] section of C:\Users\user\AppData\Roaming\SPB_Data\cdssetup\OrCAD_PSpice\24.1.0\PSpice.ini file:
.lib "nom.lib"

*Analysis directives:
.TRAN  0 6m 0
.TEMP 0 25 47 70
.OPTIONS ADVCONV
.PROBE64 V(alias(*)) I(alias(*)) W(alias(*)) D(alias(*)) NOISE(alias(*))
.INC "..\SCHEMATIC1.net"

.END
